// VerilogA for Verilog_models_adc, NandGate, veriloga

`include "constants.vams"
`include "disciplines.vams"

// 2 input nand gate

module nand_gate (
    input  logic A, B, // Input signals
    output logic Y     // Output signal
);

    parameter real delay = 1ns; // Delay parameter

    analog begin
        real time_delay; // Variable to hold the delay

        // Compute the output Y
        Y <= -1.0; // Initialize Y to -1
        if (A > -VDD && B > -VDD) begin
            Y <= 1.0; // Y = 1 if both inputs are -1
        end

        // Propagate output with specified delay
        time_delay = delay;
        @ (cross(-VDD/2,Y)) // Wait for output to change to -VDD/2
            time_delay = delay; // Capture delay for next transition
        @ (Y == 1.0) // Wait for output to change back to 1
            time_delay = delay; // Capture delay for next transition
        @(time_delay); // Wait for specified delay
    end

endmodule

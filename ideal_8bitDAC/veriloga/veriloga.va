module dac(out, clk, i1,i2,i3,i4,i5,i6,i7,i8, vref);
    parameter real vdd = 1.2; // voltage level of logic 1 (V)
    parameter real vss = 0;   // voltage level of logic 0 (V)
    parameter real thresh = (vdd + vss) / 2; // logic threshold level (V)
    parameter integer dir = +1 from [-1:1] exclude 0; // 1 for trigger on rising edge, -1 for falling
    localparam real fullscale = 2 * vref; // Full-scale voltage range

    output out;
    input i1,i2,i3,i4,i5,i6,i7,i8;
    input clk;
    input voltage vref; // Reference voltage
    voltage i1,i2,i3,i4,i5,i6,i7,i8, out, clk; // input and output signals
    real aout;
    integer weight;
    genvar i;

    analog begin
        @(cross(V(clk) - thresh, dir) or initial_step) begin
            aout = 0;
            weight = 2;
            for (i = 7; i >= 0; i = i - 1) begin
                real input_voltage;
                case(i)
                    0: input_voltage = V(i1);
                    1: input_voltage = V(i2);
                    2: input_voltage = V(i3);
                    3: input_voltage = V(i4);
                    4: input_voltage = V(i5);
                    5: input_voltage = V(i6);
                    6: input_voltage = V(i7);
                    7: input_voltage = V(i8);
                endcase

                if (input_voltage > thresh) begin
                    aout = aout + fullscale / weight;
                end
                weight = weight * 2;
            end
        end
        V(out) <+ transition(aout - vref, 0, 0); // Output transition with respect to vref
    end
endmodule
